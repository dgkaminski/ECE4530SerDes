ADE simulation setup
Test ECE4530SerDes_idealBBtb_1: ECE4530SerDes/idealBBtb/schematic, simulator spectre
  Models: /opt/cadence-designkits/gpdk045_v_6_0/gpdk045/../models/spectre/gpdk045.scs[mc]
  Variables: dly = 95p; w = 1u
  Temperature: 27
  Analysis tran: stop=10n
  Signals: /early, /late, /rearly, /rlate
Run mode: Single Run, Sweeps and Corners
Setup values for test ECE4530SerDes_idealBBtb_1: dly = 95p 105p
