ADE simulation setup
Run mode: Single Run, Sweeps and Corners
Tests:
  ECE4530SerDes_idealBBtb_1: ECE4530SerDes/idealBBtb/schematic, simulator spectre
    Variables: dly = 95p 105p; w = 1u
