ADE simulation setup
Run mode: Single Run, Sweeps and Corners
Tests:
  ECE4530SerDes_ChargePump_TB_1: ECE4530SerDes/ChargePump_TB/schematic, simulator spectre
