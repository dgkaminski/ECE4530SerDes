ADE simulation setup
Test ECE4530SerDes_ChargePump_TB_1: ECE4530SerDes/ChargePump_TB/schematic, simulator spectre
  Models: /opt/cadence-designkits/gpdk045_v_6_0/gpdk045/../models/spectre/gpdk045.scs[mc]
  Temperature: 27
  Analysis dc: (saves the operating point)
  Analysis tran: stop=25n errpreset=conservative
  Signals: /I11/vout (terminal), /I10/vout (terminal), /I4/vout (terminal), /I16/vout (terminal), /I14/vout (terminal)
Run mode: Single Run, Sweeps and Corners
