ADE simulation setup
Test final_ChannelTB_1: final/ChannelTB/schematic, simulator spectre
  Models: /opt/cadence-designkits/gpdk045_v_6_0/gpdk045/../models/spectre/gpdk045.scs[mc], /opt/cadence/IC231.007/tools.lnx86/dfII/etc/cdslib/artist/functional/allFunc.scs
  Temperature: 27
  Analysis dc: (saves the operating point)
  Analysis tran: stop=500n errpreset=conservative
  Analysis ac: start=1k stop=10G
  Signals: /net2
Run mode: Single Run, Sweeps and Corners
Setup values for test final_ChannelTB_1: num_fing = 50
