ADE simulation setup
Run mode: Single Run, Sweeps and Corners
Tests:
  final_ChannelTB_1: final/ChannelTB/schematic, simulator spectre
    Variables: num_fing = 50
