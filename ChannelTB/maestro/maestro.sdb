ADE simulation setup
Run mode: Single Run, Sweeps and Corners
Tests:
  final_ChannelTB_1: ECE4530SerDes/ChannelTB/schematic, simulator spectre
    Variables: num_fing = 10; zc = 1p
