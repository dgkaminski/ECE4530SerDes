ADE simulation setup
Test ECE4530SerDes_CMLlatch_1: ECE4530SerDes/CMLLatch1/schematic, simulator spectre
  Models: /opt/cadence-designkits/gpdk045_v_6_0/gpdk045/../models/spectre/gpdk045.scs[mc]
  Variables: ibias = 100u; rload = 3000
  Temperature: 27
  Analysis tran: stop=10n outputstart=10p
  Signals: /vinp, /vinn, /clk, /clkn, /net7, /net4
Run mode: Single Run, Sweeps and Corners
