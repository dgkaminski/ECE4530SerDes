ADE simulation setup
Run mode: Single Run, Sweeps and Corners
Tests:
  ECE4530SerDes_CMLlatch_1: ECE4530SerDes/CMLLatch1/schematic, simulator spectre
    Variables: rload = 3000; ibias = 100u
