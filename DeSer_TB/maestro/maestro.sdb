ADE simulation setup
Run mode: Single Run, Sweeps and Corners
Tests:
  ECE4530SerDes_DeSer_TB_1: ECE4530SerDes/DeSer_TB/schematic, simulator spectre
    Variables: w = 300n
