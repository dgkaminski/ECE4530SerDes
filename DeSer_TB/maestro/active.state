ADE simulation setup
Test ECE4530SerDes_DeSer_TB_1: ECE4530SerDes/DeSer_TB/schematic, simulator spectre
  Models: /opt/cadence-designkits/gpdk045_v_6_0/gpdk045/../models/spectre/gpdk045.scs[mc]
  Variables: w = 300n
  Temperature: 27
  Analysis tran: stop=8n
  Analysis dc: (saves the operating point)
Run mode: Single Run, Sweeps and Corners
