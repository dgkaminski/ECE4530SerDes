ADE simulation setup
Run mode: Single Run, Sweeps and Corners
Tests:
  ECE4530SerDes_DFE-TB_1: ECE4530SerDes/DFE-TB/schematic, simulator spectre
    Variables: idfe = 1m; num_fing = 50; tap1 = 5.2; tap2 = 12.5; tap3 = 5.7
    Outputs: ((VT("/I4/dfen") - VT("/I4/dfep") - value((VT("/I4/dfen") - VT("/I4/dfep")) 1.4e-08)) / ymax((VT("/I4/dfen") - VT("/I4/dfep") - value((VT("/I4/dfen") - VT("/I4/dfep")) 2e-08)))); ((VT("/I4/dfen") - VT("/I4/dfep") - value((VT("/I4/dfen") - VT("/I4/dfep")) 1.4e-08)) / ymax((VT("/I4/dfen") - VT("/I4/dfep") - value((VT("/I4/dfen") - VT("/I4/dfep")) 1.9e-08))))
