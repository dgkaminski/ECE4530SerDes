ADE simulation setup
Run mode: Single Run, Sweeps and Corners
Tests:
  ECE4530SerDes_DFE-TB_1: ECE4530SerDes/DFE-TB/schematic, simulator spectre
    Variables: idfe = 1m; num_fing = 50; tap1 = 25; tap2 = 2.5
