ADE simulation setup
Test ECE4530SerDes_DFE-TB_1: ECE4530SerDes/DFE-TB/schematic, simulator spectre
  Models: /opt/cadence-designkits/gpdk045_v_6_0/gpdk045/../models/spectre/gpdk045.scs[mc], /opt/cadence/IC231.007/tools.lnx86/dfII/etc/cdslib/artist/functional/allFunc.scs
  Variables: tap2 = 2.5; idfe = 1m; num_fing = 50; tap1 = 25
  Temperature: 27
  Analysis tran: stop=250n errpreset=conservative
  Output a2d_/BfrCh = awvAnalog2Digital(VT("/BfrCh") nil nil 0.72 nil "centre") (unticked)
  Output a2d_/dfep = awvAnalog2Digital(VT("/dfep") nil nil 0.75 nil "centre")
  Output "a2d_rshift(awvAnalog2Digital(VT(\"/BfrCh\") nil nil 0.72 nil \"centre\") 680p )" = awvAnalog2Digital(rshift(awvAnalog2Digital(VT("/BfrCh") nil nil 0.72 nil "centre") 6.8e-10) nil nil 2.5 nil "centre")
  Signals: /BfrCh, /AftCh, /CTLEoutp, /CLTEoutn, /clk, /clkn, /dfep, /dfen, /I4/dfen, /I4/dfep
Run mode: Single Run, Sweeps and Corners
Setup values for test ECE4530SerDes_DFE-TB_1: tap1 = 23; tap2 = 4; tap3 = 5.7; zc = 1p; nf = 1
