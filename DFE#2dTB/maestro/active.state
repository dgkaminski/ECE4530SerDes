ADE simulation setup
Test ECE4530SerDes_DFE-TB_1: ECE4530SerDes/DFE-TB/schematic, simulator spectre
  Models: /opt/cadence-designkits/gpdk045_v_6_0/gpdk045/../models/spectre/gpdk045.scs[mc], /opt/cadence/IC231.007/tools.lnx86/dfII/etc/cdslib/artist/functional/allFunc.scs
  Variables: tap3 = 5.7; tap2 = 12.5; idfe = 1m; num_fing = 50; tap1 = 5.2
  Temperature: 27
  Analysis tran: stop=20n errpreset=conservative
  Analysis dc: (saves the operating point)
  Output a2d_/BfrCh = awvAnalog2Digital(VT("/BfrCh") nil nil 0.72 nil "centre") (unticked)
  Output a2d_/dfep = awvAnalog2Digital(VT("/dfep") nil nil 0.75 nil "centre") (unticked)
  Output "a2d_rshift(awvAnalog2Digital(VT(\"/BfrCh\") nil nil 0.72 nil \"centre\") 680p )" = awvAnalog2Digital(rshift(awvAnalog2Digital(VT("/BfrCh") nil nil 0.72 nil "centre") 6.8e-10) nil nil 2.5 nil "centre") (unticked)
  Output "VT(\"/I4/dfen\") - VT(\"/I4/dfep\") - value((VT(\"/I4/dfen\") - VT(\"/I4/dfep\")) 14n   )" = (VT("/I4/dfen") - VT("/I4/dfep") - value((VT("/I4/dfen") - VT("/I4/dfep")) 1.4e-08)) (unticked)
  Output "leafValue((VT(\"/I4/dfen\") / ymax(VT(\"/I4/dfen\"))) \"tap2\" 0.0)" = (VT("/I4/dfen") / ymax(VT("/I4/dfen"))) (unticked)
  Output ((VT("/I4/dfen") - VT("/I4/dfep") - value((VT("/I4/dfen") - VT("/I4/dfep")) 1.4e-08)) / ymax((VT("/I4/dfen") - VT("/I4/dfep") - value((VT("/I4/dfen") - VT("/I4/dfep")) 1.9e-08)))) (unticked)
  Signals: /BfrCh, /AftCh, /CTLEoutp, /CLTEoutn, /clk, /clkn, /dfep, /dfen, /I4/dfen, /I4/dfep
Run mode: Single Run, Sweeps and Corners
Setup values for test ECE4530SerDes_DFE-TB_1: tap1 = 23; tap2 = 4; zc = 1p; nf = 1
