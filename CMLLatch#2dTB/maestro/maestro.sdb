ADE simulation setup
Run mode: Single Run, Sweeps and Corners
Tests:
  ECE4530SerDes_CMLLatch-TB_1: ECE4530SerDes/CMLLatch-TB/schematic, simulator spectre
