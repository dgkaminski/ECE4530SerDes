ADE simulation setup
Test ECE4530SerDes_CMLLatch-TB_1: ECE4530SerDes/CMLLatch-TB/schematic, simulator spectre
  Models: /opt/cadence-designkits/gpdk045_v_6_0/gpdk045/../models/spectre/gpdk045.scs[mc]
  Temperature: 27
  Analysis tran: stop=10n errpreset=conservative
  Analysis dc: (saves the operating point)
  Signals: /inp, /inn, /clkn, /clk, /q, /qn, /I0/net1, /I0/net2, /net10 as q1, /net9 as qn1, /net1 as q2, /net2 as qn2
Run mode: Single Run, Sweeps and Corners
