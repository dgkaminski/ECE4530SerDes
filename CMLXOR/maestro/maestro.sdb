ADE simulation setup
Run mode: Single Run, Sweeps and Corners
Tests:
  ECE4530SerDes_CMLXOR_1: ECE4530SerDes/CMLXOR/schematic, simulator spectre
    Variables: ibias = 50u; rload = 7500; w = 1u; loadw = 400n
