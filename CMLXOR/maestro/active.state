ADE simulation setup
Test ECE4530SerDes_CMLXOR_1: ECE4530SerDes/CMLXOR/schematic, simulator spectre
  Models: /opt/cadence-designkits/gpdk045_v_6_0/gpdk045/../models/spectre/gpdk045.scs[mc]
  Variables: ibias = 50u; rload = 7500; w = 400n
  Temperature: 27
  Analysis tran: stop=5n
Run mode: Single Run, Sweeps and Corners
Setup values for test ECE4530SerDes_CMLXOR_1: w = 1u; loadw = 400n
