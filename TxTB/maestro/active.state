ADE simulation setup
Test ECE4530SerDes_TxTB_1: ECE4530SerDes/TxTB/schematic, simulator spectre
  Models: /opt/cadence-designkits/gpdk045_v_6_0/gpdk045/../models/spectre/gpdk045.scs[mc], /opt/cadence/IC231.007/tools.lnx86/dfII/etc/cdslib/artist/functional/allFunc.scs
  Variables: num_fing = 25; zc = 1p; tap3 = 700u; w = 500n
  Temperature: 27
  Analysis tran: stop=15n
  Output v (/outp /outn); tran (V) = (vtime('tran "/outp") - vtime('tran "/outn"))
  Output v (/outpfir /outnfir); tran (V) = (vtime('tran "/outpfir") - vtime('tran "/outnfir"))
  Output v (/outpref /outnref); tran (V) = (vtime('tran "/outpref") - vtime('tran "/outnref"))
  Output eye_height = eyeMeasurement(eyeDiagram((vtime('tran "/outpfir") - vtime('tran "/outnfir")) 0.0 2e-07 (2 * 4e-10) ?triggerPeriod 4e-10 ?autoCenter t ?intensityPlot t) 1e-08 2e-07 8e-10 0.0 nil t 40.0 0.0 t 60.0 50.0 t 40.0 50.0 t 60.0 100.0 100.0 "height")
  Output eye_maxHeight = eyeMeasurement(eyeDiagram((vtime('tran "/outpfir") - vtime('tran "/outnfir")) 0.0 2e-07 (2 * 4e-10) ?triggerPeriod 4e-10 ?autoCenter t ?intensityPlot t) 0.0 2e-07 8e-10 0.0 nil t 40.0 0.0 t 60.0 50.0 t 40.0 50.0 t 60.0 100.0 100.0 "maxHeight")
Run mode: Single Run, Sweeps and Corners
