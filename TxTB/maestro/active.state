ADE simulation setup
Test ECE4530SerDes_TxTB_1: ECE4530SerDes/TxTB/schematic, simulator spectre
  Models: /opt/cadence-designkits/gpdk045_v_6_0/gpdk045/../models/spectre/gpdk045.scs[mc], /opt/cadence/IC231.007/tools.lnx86/dfII/etc/cdslib/artist/functional/allFunc.scs
  Variables: w = 500n
  Temperature: 27
  Analysis tran: stop=200n
  Output v (/outp /outn); tran (V) = (vtime('tran "/outp") - vtime('tran "/outn"))
  Output v (/outpfir /outnfir); tran (V) = (vtime('tran "/outpfir") - vtime('tran "/outnfir"))
  Output v (/outpref /outnref); tran (V) = (vtime('tran "/outpref") - vtime('tran "/outnref"))
Run mode: Single Run, Sweeps and Corners
