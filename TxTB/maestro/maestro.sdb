ADE simulation setup
Run mode: Single Run, Sweeps and Corners
Tests:
  ECE4530SerDes_TxTB_1: ECE4530SerDes/TxTB/schematic, simulator spectre
    Variables: w = 500n; tap3 = 700u
    Outputs: eye_height
