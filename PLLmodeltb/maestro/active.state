ADE simulation setup
Test ECE4530SerDes_PLLmodeltb_1: ECE4530SerDes/PLLmodeltb/schematic, simulator spectre
  Models: /opt/cadence-designkits/gpdk045_v_6_0/gpdk045/../models/spectre/gpdk045.scs[mc]
  Variables: bias = 63.5u
  Temperature: 27
  Analysis tran: stop=5u
  Output freq(VT("/vout") "rising" ?xName "time" ?mode "auto" ?threshold 0.6)
  Output clip(freq(VT("/vout") "rising" ?xName "time" ?mode "auto" ?threshold 0.6) 4e-09 3e-07) (unticked)
  Signals: /vout, /I0/iout (terminal), /I1/biasc (terminal), /I25/biasf (terminal), /I25/biasc (terminal), /I25/vout (terminal), /I25/vdd (terminal), /I25/gnd (terminal), /pll2loop, /net7, /I29/net8
Run mode: Single Run, Sweeps and Corners
