ADE simulation setup
Test ECE4530SerDes_PLLmodeltb_1: ECE4530SerDes/PLLmodeltb/schematic, simulator spectre
  Models: /opt/cadence-designkits/gpdk045_v_6_0/gpdk045/../models/spectre/gpdk045.scs[mc]
  Variables: bias = 63.5u
  Temperature: 27
  Analysis tran: stop=300n
  Output freq(VT("/vout") "rising" ?xName "time" ?mode "auto" ?threshold 0.6) (unticked)
  Output clip(freq(VT("/vout") "rising" ?xName "time" ?mode "auto" ?threshold 0.6) 4e-09 3e-07)
  Signals: /vout, /I0/iout (terminal), /I1/biasc (terminal), /I29/iout (terminal)
Run mode: Single Run, Sweeps and Corners
