ADE simulation setup
Run mode: Single Run, Sweeps and Corners
Tests:
  final_ChannelModelRazavi_1: final/ChannelModelRazavi/schematic, simulator spectre
