ADE simulation setup
Test final_ChannelModelRazavi_1: final/ChannelModelRazavi/schematic, simulator spectre
  Models: /opt/cadence-designkits/gpdk045_v_6_0/gpdk045/../models/spectre/gpdk045.scs[mc]
  Temperature: 27
  Analysis dc: (saves the operating point)
  Analysis tran: stop=20n errpreset=conservative
  Output dft(VT("/net3") 0 0 64 "Rectangular" 1 "default" 1.0)
  Signals: /net3
Run mode: Single Run, Sweeps and Corners
