ADE simulation setup
Test final_ChannelModelRazavi_1: final/ChannelModelRazavi/schematic, simulator spectre
  Models: /opt/cadence-designkits/gpdk045_v_6_0/gpdk045/../models/spectre/gpdk045.scs[mc]
  Temperature: 27
  Analysis dc: (saves the operating point)
  Analysis tran: stop=200n errpreset=conservative
  Output v /net2; tran (V) = vtime('tran "/net2")
Run mode: Single Run, Sweeps and Corners
