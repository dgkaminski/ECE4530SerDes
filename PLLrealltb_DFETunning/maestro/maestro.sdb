ADE simulation setup
Run mode: Single Run, Sweeps and Corners
Tests:
  ECE4530SerDes_PLLmodeltb_1: ECE4530SerDes/PLLrealltb_DFETunning/schematic, simulator spectre
    Variables: tap1 = 4; tap2 = 6; tap3 = 3; dfedly = -140p
    Outputs: clip(freq(VT("/vout") "rising" ?xName "time" ?mode "auto" ?threshold 0.6) 4e-09 5e-08); clip(freq(VT("/vout") "rising" ?xName "time" ?mode "auto" ?threshold 0.6) 4e-09 1e-07); clip(freq(VT("/vout") "rising" ?xName "time" ?mode "auto" ?threshold 0.6) 4e-09 1.5e-07); clip(freq(VT("/vout") "rising" ?xName "time" ?mode "auto" ?threshold 0.6) 4e-09 2e-07)
