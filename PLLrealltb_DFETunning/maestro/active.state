ADE simulation setup
Test ECE4530SerDes_PLLmodeltb_1: ECE4530SerDes/PLLrealltb_DFETunning/schematic, simulator spectre
  Models: /opt/cadence-designkits/gpdk045_v_6_0/gpdk045/../models/spectre/gpdk045.scs[mc], /opt/cadence/IC231.007/tools.lnx86/dfII/etc/cdslib/artist/functional/allFunc.scs
  Variables: dfedly = -140p; tap1 = 4; tap2 = 6; tap3 = 3
  Temperature: 27
  Analysis tran: stop=100n
  Signals: /clkdfep, /clkdfen, /outp, /outn, /AftCh, /AftChN, /ctleoutp, /ctleoutn, /dfep, /dfen
Run mode: Single Run, Sweeps and Corners
