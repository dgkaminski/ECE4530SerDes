ADE simulation setup
Test ECE4530SerDes_CMOS_Ser_1: ECE4530SerDes/CMOS_Ser/schematic, simulator spectre
  Models: /opt/cadence-designkits/gpdk045_v_6_0/gpdk045/../models/spectre/gpdk045.scs[mc]
  Temperature: 27
  Analysis tran: stop=5n
Run mode: Single Run, Sweeps and Corners
