ADE simulation setup
Run mode: Single Run, Sweeps and Corners
Tests:
  ECE4530SerDes_CMOS_Ser_1: ECE4530SerDes/CMOS_Ser/schematic, simulator spectre
