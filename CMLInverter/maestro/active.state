ADE simulation setup
Test ECE4530SerDes_CMLlatch_1: ECE4530SerDes/CMLInverter/schematic, simulator spectre
  Models: /opt/cadence-designkits/gpdk045_v_6_0/gpdk045/../models/spectre/gpdk045.scs[mc]
  Variables: ibias = 100u; rload = 5000
  Temperature: 27
  Analysis tran: stop=10n outputstart=10p
  Signals: /vinp, /vinn, /vn1, /vp1, /net3, /net2, /R4/MINUS (terminal), /net6, /net9, /net8
Run mode: Single Run, Sweeps and Corners
