ADE simulation setup
Run mode: Single Run, Sweeps and Corners
Tests:
  ECE4530SerDes_CMLlatch_1: ECE4530SerDes/CMLInverter/schematic, simulator spectre
    Variables: rload = 5000; ibias = 100u
