ADE simulation setup
Run mode: Single Run, Sweeps and Corners
Tests:
  ECE4530SerDes_VtoI_1: ECE4530SerDes/VtoI2/schematic, simulator spectre
    Variables: vinp = 600m
