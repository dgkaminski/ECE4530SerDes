ADE simulation setup
Test ECE4530SerDes_VtoI_1: ECE4530SerDes/VtoI2/schematic, simulator spectre
  Models: /opt/cadence-designkits/gpdk045_v_6_0/gpdk045/../models/spectre/gpdk045.scs[mc]
  Variables: vinp = 600m
  Temperature: 27
  Stimulus gnd: voltage dc dc=0 srcType=dc
  Stimulus ibias: current dc dc=-2.5u srcType=dc
  Stimulus vdd: voltage dc dc=1.2 srcType=dc
  Stimulus vinp: voltage dc dc=vinp mag=1 srcType=dc
  Analysis dc: sweep vinp start=0 stop=1.2 (saves the operating point)
  Analysis ac: start=1 stop=10G
  Signals: /PM10/D (terminal), /vinp, /iout
Run mode: Single Run, Sweeps and Corners
