ADE simulation setup
Test ECE4530SerDes_PLLmodeltb_1: ECE4530SerDes/PLLrealltb_updated2/schematic, simulator spectre
  Models: /opt/cadence-designkits/gpdk045_v_6_0/gpdk045/../models/spectre/gpdk045.scs[mc], /opt/cadence/IC231.007/tools.lnx86/dfII/etc/cdslib/artist/functional/allFunc.scs
  Temperature: 27
  Analysis dc: (saves the operating point)
  Output freq(VT("/vout") "rising" ?xName "time" ?mode "auto" ?threshold 0.6)
  Output clip(freq(VT("/vout") "rising" ?xName "time" ?mode "auto" ?threshold 0.6) 4e-09 3e-07) (unticked)
  Signals: /vout, /net2, /pll2loop, /I85/ibias (terminal), /iout2, /data_a, /data_b, /data_c, /data_d, /v_one, /v_zero, /I85/vout (terminal), /ctleoutp, /ctleoutn, /I92/ibias (terminal), /I92/ibiasx_4 (terminal), /I92/ibiasx20 (terminal), /I92/ibiasx6 (terminal), /I92/ibiasx4 (terminal), /I92/ibiasx1 (terminal), /I92/ibias_x_4 (terminal), /I92/ibias_x20 (terminal), /I92/ibias_x1 (terminal), /I92/vdd (terminal), /I92/ibias_x_20 (terminal), /I92/ibias_tx (terminal)
Run mode: Single Run, Sweeps and Corners
Setup values for test ECE4530SerDes_PLLmodeltb_1: bias = 63.5u; w = 1u; num_fing = 10; zc = 1p; idfe = 1m; tap1 = 15; tap2 = 1; tap3 = 4
