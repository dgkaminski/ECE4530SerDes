ADE simulation setup
Test final_ChannelTB_1: ECE4530SerDes/Postcursors/schematic, simulator spectre
  Models: /opt/cadence-designkits/gpdk045_v_6_0/gpdk045/../models/spectre/gpdk045.scs[mc], /opt/cadence/IC231.007/tools.lnx86/dfII/etc/cdslib/artist/functional/allFunc.scs
  Variables: num_fing = 50
  Temperature: 27
  Analysis tran: stop=5n errpreset=conservative
  Analysis dc: (saves the operating point)
  Output "(VT(\"/CTLEoutp\") - VT(\"/CLTEoutn\")) - (VDC(\"/CTLEoutp\") - VDC(\"/CLTEoutn\"))" = (VT("/CTLEoutp") - VT("/CLTEoutn") - (VDC("/CTLEoutp") - VDC("/CLTEoutn"))) (unticked)
  Output (VT("/CTLEoutp") - VT("/CLTEoutn")) (unticked)
  Output "VT(\"/CTLEoutp\") - VT(\"/CLTEoutn\") - value(VT(\"/CTLEoutp\") - VT(\"/CLTEoutn\") lastVal(VT(\"/CTLEoutp\") - VT(\"/CLTEoutn\"))   )" = (VT("/CTLEoutp") - VT("/CLTEoutn") - value((VT("/CTLEoutp") - VT("/CLTEoutn")) lastVal((VT("/CTLEoutp") - VT("/CLTEoutn")))))
  Signals: /BfrCh, /AftCh, /CTLEoutp, /CLTEoutn
Run mode: Single Run, Sweeps and Corners
