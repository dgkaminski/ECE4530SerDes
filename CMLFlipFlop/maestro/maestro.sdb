ADE simulation setup
Run mode: Single Run, Sweeps and Corners
Tests:
  ECE4530SerDes_CMLlatch_1: ECE4530SerDes/CMLFlipFlop/schematic, simulator spectre
    Variables: rload = 15000; ibias = 10u; ibias2 = 10u
