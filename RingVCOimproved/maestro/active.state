ADE simulation setup
Test ECE4530SerDes_RingVCO_1: ECE4530SerDes/RingVCOimproved/schematic, simulator spectre
  Models: /opt/cadence-designkits/gpdk045_v_6_0/gpdk045/../models/spectre/gpdk045.scs[tt]
  Variables: biasf = 0u; biasc = 60u
  Temperature: 27
  Stimulus biasc: current dc dc=-biasc srcType=dc
  Stimulus gnd: voltage dc dc=0 srcType=dc
  Stimulus vdd: voltage pwl dc=1.2 pwlfilter=  tvpairs=2 t1=0 v1=0 t2=1n v2=1.2 v3=0 v4=0 v5=0 v6=0 v7=0 v8=0 v9=0 v10=0 v11=0 v12=0 v13=0 v14=0 v15=0 v16=0 v17=0 v18=0 v19=0 v20=0 v21=0 v22=0 v23=0 v24=0 v25=0 v26=0 v27=0 v28=0 v29=0 v30=0 v31=0 v32=0 v33=0 v34=0 v35=0 v36=0 v37=0 v38=0 v39=0 v40=0 v41=0 v42=0 v43=0 v44=0 v45=0 v46=0 v47=0 v48=0 v49=0 v50=0 srcType=pwl
  Stimulus biasf: current dc dc=-biasf srcType=dc
  Analysis tran: stop=50n errpreset=conservative maxstep=1p noisefmax=100G
  Analysis hb: sweep biasc start=30u stop=120u lin=30 fundfreqs=("(2.5G)") maxharms=("5") tstab=auto oscana=t p=/v4 n=/net5 errpreset=conservative skipdc=sigrampup
  Output dft(VT("/v4b") 4e-08 5e-08 1028 "Rectangular" 1 "default" 1.0) (unticked)
  Output ymax(clip(freq(VT("/v4b") "rising" ?xName "time" ?mode "auto" ?threshold 0.6) 1e-08 5e-08)) (unticked)
  Output "ymax(clip(freq(VT(\"/net2\") \"rising\" ?xName \"time\" ?mode \"auto\" ?threshold 0.6) 10n 50n ))" = ymax(clip(freq(VT("/v4b") "rising" ?xName "time" ?mode "auto" ?threshold 0.6) 1e-08 5e-08)) (unticked)
  Output "deriv(ymax(clip(freq(VT(\"/net2\") \"rising\" ?xName \"time\" ?mode \"auto\" ?threshold 0.6) 10n 50n )))" = deriv(ymax(clip(freq(VT("/net2") "rising" ?xName "time" ?mode "auto" ?threshold 0.6) 1e-08 5e-08))) (unticked)
  Output harm=1 freq; hb (Hz) = harmonic(xval(getData("v4" ?result "hb_fd")) '1)
  Output Kvco = (deriv(harmonic(xval(getData("v4" ?result "hb_fd")) 1)) * 1e-06)
  Output freq(VT("/vout") "rising" ?xName "time" ?mode "auto" ?threshold 0.6)
  Signals: /v1, /v2, /PM9/D (terminal), /PM7/D (terminal), /PM8/D (terminal), /vout
Run mode: Single Run, Sweeps and Corners
Corners:
  model folders: /opt/cadence-designkits/gpdk045_v_6_0/gpdk045/../models/spectre
  ff (off): gpdk045.scs[ff]
  ss (off): gpdk045.scs[ss]
