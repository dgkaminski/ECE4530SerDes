ADE simulation setup
Run mode: Single Run, Sweeps and Corners
Tests:
  ECE4530SerDes_RingVCO_1: ECE4530SerDes/RingVCOimproved/schematic, simulator spectre
    Variables: biasf = 0u; biasc = 60u
    Outputs: dft(VT("/net2") 2e-08 4e-09 1028 "Rectangular" 1 "default" 1.0); dft(VT("/net2") 4e-08 4.5e-08 1028 "Rectangular" 1 "default" 1.0); dft(VT("/net2") 4e-08 5e-08 1028 "Rectangular" 1 "default" 1.0); /v1; /v2; /v3; dft(VT("/v3") 4e-08 5e-08 1028 "Rectangular" 1 "default" 1.0); ymax(clip(freq(VT("/v3") "rising" ?xName "time" ?mode "auto" ?threshold 0.6) 1e-08 5e-08)); ymax(clip(freq(VT("/net2") "rising" ?xName "time" ?mode "auto" ?threshold 0.6) 10n 50n )); dft(VT("/v4b") 4e-08 5e-08 1028 "Rectangular" 1 "default" 1.0); ymax(clip(freq(VT("/v4b") "rising" ?xName "time" ?mode "auto" ?threshold 0.6) 1e-08 5e-08))
Corners:
  model folders: /opt/cadence-designkits/gpdk045_v_6_0/gpdk045/../models/spectre
  ff (off): gpdk045.scs[ff]
  ss (off): gpdk045.scs[ss]
