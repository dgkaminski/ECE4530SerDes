ADE simulation setup
Test ECE4530SerDes_PLLmodeltb_1: ECE4530SerDes/PLLrealltb_pllTxCh/schematic, simulator spectre
  Models: /opt/cadence-designkits/gpdk045_v_6_0/gpdk045/../models/spectre/gpdk045.scs[mc], /opt/cadence/IC231.007/tools.lnx86/dfII/etc/cdslib/artist/functional/allFunc.scs
  Variables: idfe = 1m; tap1 = 15; tap2 = 1; tap3 = 4; num_fing = 10; zc = 1p; w = 1u; bias = 63.5u
  Temperature: 27
  Analysis tran: stop=1u
  Signals: /net26, /vout, /iout2, /pll2out, /net20, /clkppll, /gnd!, /pll2ref, /net9, /10u_3, /vdd!, /clknpll, /inp, /vdd, /outn, /net19, /ctleoutn, /net18, /net21, /ctleoutp, /net10, /net6, /outp, /net11, /net15, /net27, /net29, /net30, /net7, /net8, /pll2loop, /50u_tx, /inn, /net17, /net2, /10u_1, /clkp, /clkn, /net23, /15u, /10u_2, /2poin5u_2, /AftCh, /AftChN, /2point5u, /net46, /C22/PLUS (terminal), /C22/MINUS (terminal), /I64/gnd! (terminal), /NM3/S (terminal), /NM3/G (terminal), /NM3/B (terminal), /NM3/D (terminal), /NM2/S (terminal), /NM2/G (terminal), /NM2/B (terminal), /NM2/D (terminal), /R13/PLUS (terminal), /R13/MINUS (terminal), /C20/PLUS (terminal), /C20/MINUS (terminal), /I44/B (terminal), /I44/A (terminal), /I44/Y (terminal), /V9/MINUS (terminal), /V9/PLUS (terminal), /V12/MINUS (terminal), /V12/PLUS (terminal), /PM0/S (terminal), /PM0/G (terminal), /PM0/B (terminal), /PM0/D (terminal), /PM1/S (terminal), /PM1/G (terminal), /PM1/B (terminal), /PM1/D (terminal), /R14/PLUS (terminal), /R14/MINUS (terminal), /I29/vinp (terminal), /I29/iout2 (terminal), /I29/vdd (terminal), /I29/ibias (terminal), /I29/gnd (terminal), /I29/iout1 (terminal), /I25/biasf (terminal), /I25/biasc (terminal), /I25/vout (terminal), /I25/vdd (terminal), /I25/gnd (terminal), /I25/pcont (terminal), /I95/dst (terminal), /I95/src (terminal), /I37/noConn (terminal), /C0/PLUS (terminal), /C0/MINUS (terminal), /I102/noConn (terminal), /I39/gnd! (terminal), /I71/gnd! (terminal), /I101/noConn (terminal), /R3/PLUS (terminal), /R3/MINUS (terminal), /C7/PLUS (terminal), /C7/MINUS (terminal), /V15/MINUS (terminal), /V15/PLUS (terminal), /V14/MINUS (terminal), /V14/PLUS (terminal), /V7/MINUS (terminal), /V7/PLUS (terminal), /V4/PLUS (terminal), /V4/MINUS (terminal), /I104/noConn (terminal), /I72/in (terminal), /I72/out (terminal), /I103/noConn (terminal), /R4/PLUS (terminal), /R4/MINUS (terminal), /M0/S (terminal), /M0/G (terminal), /M0/D (terminal), /M0/B (terminal), /I68/vinp (terminal), /I68/iout (terminal), /I68/vdd (terminal), /I68/ibias (terminal), /I68/gnd (terminal), /I73/in (terminal), /I73/out (terminal), /I67/frefp (terminal), /I67/frefn (terminal), /I67/clkpllpc (terminal), /I67/late (terminal), /I67/early (terminal), /I67/vdd (terminal), /I67/ibias (terminal), /I67/vss (terminal), /I67/clkpllp (terminal), /I67/clkplln (terminal), /I85/upbar (terminal), /I85/down (terminal), /I85/vout (terminal), /I85/ibias (terminal), /I85/vdd (terminal), /I85/gnd (terminal), /I74/in- (terminal), /I74/in+ (terminal), /I74/out- (terminal), /I74/out+ (terminal), /I74/vdd (terminal), /I74/gnd (terminal), /R5/PLUS (terminal), /R5/MINUS (terminal), /R6/PLUS (terminal), /R6/MINUS (terminal), /I9/vout (terminal), /I9/vin (terminal), /M1/S (terminal), /M1/G (terminal), /M1/D (terminal), /M1/B (terminal), /NM0/S (terminal), /NM0/G (terminal), /NM0/B (terminal), /NM0/D (terminal), /I70/biasf (terminal), /I70/biasc (terminal), /I70/vout (terminal), /I70/vdd (terminal), /I70/gnd (terminal), /I70/pcont (terminal), /I76/clkn (terminal), /I76/clkp (terminal), /I76/inn (terminal), /I76/inp (terminal), /I76/outn3 (terminal), /I76/outp3 (terminal), /I76/outn2 (terminal), /I76/outp2 (terminal), /I76/outn1 (terminal), /I76/outp1 (terminal), /I76/vdd (terminal), /I76/ibias (terminal), /I76/vss (terminal), /PM2/S (terminal), /PM2/G (terminal), /PM2/B (terminal), /PM2/D (terminal), /NM5/S (terminal), /NM5/G (terminal), /NM5/B (terminal), /NM5/D (terminal), /NM4/S (terminal), /NM4/G (terminal), /NM4/B (terminal), /NM4/D (terminal), /PM5/S (terminal), /PM5/G (terminal), /PM5/B (terminal), /PM5/D (terminal), /PM3/S (terminal), /PM3/G (terminal), /PM3/B (terminal), /PM3/D (terminal), /I81/inp1 (terminal), /I81/inn1 (terminal), /I81/outp (terminal), /I81/outn (terminal), /I81/vss (terminal), /I81/vdd (terminal), /I81/ibias (terminal), /I81/inp2 (terminal), /I81/inp0 (terminal), /I81/inn2 (terminal), /I81/inn0 (terminal), /C3/PLUS (terminal), /C3/MINUS (terminal), /C4/PLUS (terminal), /C4/MINUS (terminal), /I90/gnd! (terminal), /I99/noConn (terminal), /I98/noConn (terminal), /I91/MINUS (terminal), /I91/PLUS (terminal), /V13/MINUS (terminal), /V13/PLUS (terminal), /I96/noConn (terminal), /I92/ibias (terminal), /I92/ibiasx_4 (terminal), /I92/ibiasx20 (terminal), /I92/ibiasx6 (terminal), /I92/ibiasx4 (terminal), /I92/ibiasx1 (terminal), /I92/ibias_x_4 (terminal), /I92/ibias_x20 (terminal), /I92/ibias_x1 (terminal), /I92/vdd (terminal), /I92/ibias_x_20 (terminal), /I92/ibias_tx (terminal)
Run mode: Single Run, Sweeps and Corners
