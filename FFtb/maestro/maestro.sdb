ADE simulation setup
Run mode: Single Run, Sweeps and Corners
Tests:
  ECE4530SerDes_CMLlatch_1: ECE4530SerDes/FFtb/schematic, simulator spectre
