ADE simulation setup
Test ECE4530SerDes_CMLlatch_1: ECE4530SerDes/FFtb/schematic, simulator spectre
  Models: /opt/cadence-designkits/gpdk045_v_6_0/gpdk045/../models/spectre/gpdk045.scs[mc]
  Temperature: 27
  Analysis tran: stop=10n outputstart=10p
  Signals: /V0/PLUS (terminal), /Q, /Qb, /clk, /vinp
Run mode: Single Run, Sweeps and Corners
