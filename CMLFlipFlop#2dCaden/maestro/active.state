ADE simulation setup
Test ECE4530SerDes_CMLlatch_1: ECE4530SerDes/CMLFlipFlop/schematic, simulator spectre
  Models: /opt/cadence-designkits/gpdk045_v_6_0/gpdk045/../models/spectre/gpdk045.scs[mc]
  Variables: ibias2 = 50u; ibias = 50u; rload = 7500; w = 300n
  Temperature: 27
  Analysis tran: stop=10n outputstart=10p
  Signals: /vinp, /vinn, /clk, /clkn, /out1n, /out1p, /out2n, /out2p
Run mode: Single Run, Sweeps and Corners
