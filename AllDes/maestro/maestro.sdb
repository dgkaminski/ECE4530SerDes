ADE simulation setup
Run mode: Single Run, Sweeps and Corners
Tests:
  ECE4530SerDes_PLLmodeltb_1: ECE4530SerDes/PLLrealltb_updated2/schematic, simulator spectre
    Outputs: clip(freq(VT("/vout") "rising" ?xName "time" ?mode "auto" ?threshold 0.6) 4e-09 5e-08); clip(freq(VT("/vout") "rising" ?xName "time" ?mode "auto" ?threshold 0.6) 4e-09 1e-07); clip(freq(VT("/vout") "rising" ?xName "time" ?mode "auto" ?threshold 0.6) 4e-09 1.5e-07); clip(freq(VT("/vout") "rising" ?xName "time" ?mode "auto" ?threshold 0.6) 4e-09 2e-07); clip(freq(VT("/vout") "rising" ?xName "time" ?mode "auto" ?threshold 0.6) 4e-09 3e-07)
