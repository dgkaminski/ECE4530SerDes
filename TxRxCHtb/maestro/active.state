ADE simulation setup
Test ECE4530SerDes_TxRxCHtb_1: ECE4530SerDes/TxRxCHtb/schematic, simulator spectre
  Models: /opt/cadence-designkits/gpdk045_v_6_0/gpdk045/../models/spectre/gpdk045.scs[mc], /opt/cadence/IC231.007/tools.lnx86/dfII/etc/cdslib/artist/functional/allFunc.scs
  Variables: idfe = 1m; num_fing = 10; tap1 = 15; tap2 = 0; tap3 = 2; zc = 1p
  Temperature: 27
  Analysis tran: stop=150n
  Output v (/I4/dfep /I4/dfen); tran (V) = (vtime('tran "/I4/dfep") - vtime('tran "/I4/dfen"))
  Output v (/AftCh /AftChN); tran (V) = (vtime('tran "/AftCh") - vtime('tran "/AftChN"))
  Output v (/CTLEoutp /CLTEoutn); tran (V) = (vtime('tran "/CTLEoutp") - vtime('tran "/CLTEoutn"))
Run mode: Single Run, Sweeps and Corners
Setup values for test ECE4530SerDes_TxRxCHtb_1: num_fing = 50; tap1 = 5.2; tap2 = 12.5; tap3 = 5.7
