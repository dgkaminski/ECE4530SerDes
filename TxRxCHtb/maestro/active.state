ADE simulation setup
Test ECE4530SerDes_TxRxCHtb_1: ECE4530SerDes/TxRxCHtb/schematic, simulator spectre
  Models: /opt/cadence-designkits/gpdk045_v_6_0/gpdk045/../models/spectre/gpdk045.scs[mc], /opt/cadence/IC231.007/tools.lnx86/dfII/etc/cdslib/artist/functional/allFunc.scs
  Variables: idfe = 1m; num_fing = 50; tap1 = 5.2; tap2 = 12.5; tap3 = 5.7
  Temperature: 27
  Analysis tran: stop=100n
  Signals: /dfep, /dfen, /CTLEoutp, /CLTEoutn, /AftCh, /AftChN, /outp, /outn
Run mode: Single Run, Sweeps and Corners
