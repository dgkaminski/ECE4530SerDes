ADE simulation setup
Run mode: Single Run, Sweeps and Corners
Tests:
  ECE4530SerDes_TxRxCHtb_1: ECE4530SerDes/TxRxCHtb/schematic, simulator spectre
    Variables: idfe = 1m; num_fing = 50; tap1 = 5; tap2 = 0; tap3 = 0; zc = 1p
