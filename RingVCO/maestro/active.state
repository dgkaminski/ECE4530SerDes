ADE simulation setup
Test ECE4530SerDes_RingVCO_1: ECE4530SerDes/RingVCO/schematic, simulator spectre
  Models: /opt/cadence-designkits/gpdk045_v_6_0/gpdk045/../models/spectre/gpdk045.scs[mc]
  Variables: ibias = 10u
  Temperature: 27
  Stimulus ibias: current dc dc=ibias srcType=dc
  Stimulus gnd: voltage dc dc=0 srcType=dc
  Stimulus vdd: voltage dc dc=1.2 srcType=dc
  Analysis tran: stop=50n errpreset=conservative maxstep=100f skipdc=rampup
  Output dft(VT("/v4b") 4e-08 5e-08 1028 "Rectangular" 1 "default" 1.0)
  Output ymax(clip(freq(VT("/v4b") "rising" ?xName "time" ?mode "auto" ?threshold 0.6) 1e-08 5e-08))
  Output "ymax(clip(freq(VT(\"/net2\") \"rising\" ?xName \"time\" ?mode \"auto\" ?threshold 0.6) 10n 50n ))" = ymax(clip(freq(VT("/v4b") "rising" ?xName "time" ?mode "auto" ?threshold 0.6) 1e-08 5e-08))
  Output "deriv(ymax(clip(freq(VT(\"/net2\") \"rising\" ?xName \"time\" ?mode \"auto\" ?threshold 0.6) 10n 50n )))" = deriv(ymax(clip(freq(VT("/net2") "rising" ?xName "time" ?mode "auto" ?threshold 0.6) 1e-08 5e-08))) (unticked)
  Signals: /v1, /v2, /v3, /PM9/D (terminal), /PM6/D (terminal), /PM7/D (terminal), /PM8/D (terminal), /v4b
Run mode: Single Run, Sweeps and Corners
Setup values for test ECE4530SerDes_RingVCO_1: ibias = {From/To}Auto:10u:30:70u{From/To}
