ADE simulation setup
Test ECE4530SerDes_RingVCO_1: ECE4530SerDes/RingVCO/schematic, simulator spectre
  Models: /opt/cadence-designkits/gpdk045_v_6_0/gpdk045/../models/spectre/gpdk045.scs[tt]
  Variables: biasf = 0u; biasc = 32u
  Temperature: 27
  Stimulus biasc: current dc dc=-biasc srcType=dc
  Stimulus gnd: voltage dc dc=0 srcType=dc
  Stimulus vdd: voltage dc dc=1.2 srcType=dc
  Stimulus biasf: current dc dc=-biasf srcType=dc
  Analysis hb: sweep biasc start=24u stop=100u lin=30 fundfreqs=("(2.5G)") maxharms=("5") tstab=auto oscana=t p=/v4 n=/net5 errpreset=conservative skipdc=sigrampup
  Output dft(VT("/v4b") 4e-08 5e-08 1028 "Rectangular" 1 "default" 1.0)
  Output ymax(clip(freq(VT("/v4b") "rising" ?xName "time" ?mode "auto" ?threshold 0.6) 1e-08 5e-08))
  Output "ymax(clip(freq(VT(\"/net2\") \"rising\" ?xName \"time\" ?mode \"auto\" ?threshold 0.6) 10n 50n ))" = ymax(clip(freq(VT("/v4b") "rising" ?xName "time" ?mode "auto" ?threshold 0.6) 1e-08 5e-08))
  Output "deriv(ymax(clip(freq(VT(\"/net2\") \"rising\" ?xName \"time\" ?mode \"auto\" ?threshold 0.6) 10n 50n )))" = deriv(ymax(clip(freq(VT("/net2") "rising" ?xName "time" ?mode "auto" ?threshold 0.6) 1e-08 5e-08))) (unticked)
  Output harm=1 freq; hb (Hz) = harmonic(xval(getData("v4" ?result "hb_fd")) '1)
  Output Kvco = (deriv(harmonic(xval(getData("v4" ?result "hb_fd")) 1)) * 1e-06)
  Signals: /v1, /v2, /v3, /PM9/D (terminal), /PM6/D (terminal), /PM7/D (terminal), /PM8/D (terminal), /v4b
Run mode: Single Run, Sweeps and Corners
Setup values for test ECE4530SerDes_RingVCO_1: ibias = {From/To}Auto:10u:30:70u{From/To}
