ADE simulation setup
Run mode: Single Run, Sweeps and Corners
Tests:
  ECE4530SerDes_FFTB-DFE_1: ECE4530SerDes/FFTB-DFE/schematic, simulator spectre
