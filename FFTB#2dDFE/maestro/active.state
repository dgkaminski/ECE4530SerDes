ADE simulation setup
Test ECE4530SerDes_FFTB-DFE_1: ECE4530SerDes/FFTB-DFE/schematic, simulator spectre
  Models: /opt/cadence-designkits/gpdk045_v_6_0/gpdk045/../models/spectre/gpdk045.scs[mc]
  Temperature: 27
  Analysis tran: stop=25n errpreset=conservative
  Analysis dc: (saves the operating point)
  Signals: /clkn, /clk, /inn, /inp, /q, /qn, /I0/vx, /I0/vy, /I0/net12, /I0/net4
Run mode: Single Run, Sweeps and Corners
