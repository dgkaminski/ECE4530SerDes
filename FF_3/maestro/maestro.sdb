ADE simulation setup
Run mode: Single Run, Sweeps and Corners
Tests:
  ECE4740_Lab3_DFF_Alt_v1_1: ECE4740_Lab3/DFF_Alt_v1/layout, simulator spectre
