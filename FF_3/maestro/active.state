ADE simulation setup
Test ECE4740_Lab3_DFF_Alt_v1_1: ECE4740_Lab3/DFF_Alt_v1/layout, simulator spectre
  Models: /opt/cadence-designkits/gpdk045_v_6_0/gpdk045/../models/spectre/gpdk045.scs[mc]
  Temperature: 27
Run mode: Single Run, Sweeps and Corners
