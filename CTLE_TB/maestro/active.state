ADE simulation setup
Test final_CTLE_TB_1: final/CTLE_TB/schematic, simulator spectre
  Models: /opt/cadence-designkits/gpdk045_v_6_0/gpdk045/../models/spectre/gpdk045.scs[mc]
  Temperature: 27
  Analysis dc: (saves the operating point)
  Analysis ac: start=1 stop=10G
Run mode: Single Run, Sweeps and Corners
Setup values for test final_CTLE_TB_1: num_fing = 10; zc = 1p
