ADE simulation setup
Test final_CTLE_TB_1: final/CTLE_TB/schematic, simulator spectre
  Models: /opt/cadence-designkits/gpdk045_v_6_0/gpdk045/../models/spectre/gpdk045.scs[mc]
  Variables: num_fing = 50
  Temperature: 27
  Analysis dc: (saves the operating point)
  Analysis ac: start=1 stop=10G
  Output v /net4; ac dB20(V) = db(vfreq('ac "/net4"))
  Output Max Gain = ymax(db(vfreq('ac "/net4")))
  Output Peaking = (ymax(db(vfreq('ac "/net4"))) - ymin(db(vfreq('ac "/net4"))))
Run mode: Single Run, Sweeps and Corners
Setup values for test final_CTLE_TB_1: num_fing = 10; zc = 1p
