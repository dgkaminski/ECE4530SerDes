ADE simulation setup
Run mode: Single Run, Sweeps and Corners
Tests:
  final_CTLE_TB_1: ECE4530SerDes/CTLE_TB/schematic, simulator spectre
    Variables: num_fing = 10; zc = 215f
