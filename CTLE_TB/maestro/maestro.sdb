ADE simulation setup
Run mode: Single Run, Sweeps and Corners
Tests:
  final_CTLE_TB_1: final/CTLE_TB/schematic, simulator spectre
