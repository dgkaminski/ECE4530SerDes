ADE simulation setup
Test ECE4530SerDes_VtoI_1: ECE4530SerDes/VtoI/schematic, simulator spectre
  Models: /opt/cadence-designkits/gpdk045_v_6_0/gpdk045/../models/spectre/gpdk045.scs[mc]
  Variables: ibias = 1u; res = 50; vinp = 0.6
  Temperature: 27
  Stimulus gnd: voltage dc dc=0 srcType=dc
  Analysis dc: sweep vinp start=0 stop=1.2 (saves the operating point)
  Signals: /net6, /R0/MINUS (terminal), /PM10/D (terminal)
Run mode: Single Run, Sweeps and Corners
