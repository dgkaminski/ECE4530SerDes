ADE simulation setup
Run mode: Single Run, Sweeps and Corners
Tests:
  ECE4530SerDes_VtoI_1: ECE4530SerDes/VtoI/schematic, simulator spectre
    Variables: vinp = 0.6; res = 50; ibias = 1u
