ADE simulation setup
Run mode: Single Run, Sweeps and Corners
Tests:
  ECE4530SerDes_BigCurrentMirror_TB_1: ECE4530SerDes/BigCurrentMirror_TB/schematic, simulator spectre
