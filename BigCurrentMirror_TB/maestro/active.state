ADE simulation setup
Test ECE4530SerDes_BigCurrentMirror_TB_1: ECE4530SerDes/BigCurrentMirror_TB/schematic, simulator spectre
  Models: /opt/cadence-designkits/gpdk045_v_6_0/gpdk045/../models/spectre/gpdk045.scs[mc]
  Temperature: 27
  Analysis dc: (saves the operating point)
  Analysis tran: stop=1u
Run mode: Single Run, Sweeps and Corners
