ADE simulation setup
Test ECE4530SerDes_PLLmodeltb_1: ECE4530SerDes/PLLrealltb_updated/schematic, simulator spectre
  Models: /opt/cadence-designkits/gpdk045_v_6_0/gpdk045/../models/spectre/gpdk045.scs[mc], /opt/cadence/IC231.007/tools.lnx86/dfII/etc/cdslib/artist/functional/allFunc.scs
  Variables: idfe = 1m; tap1 = 15; tap2 = 0; tap3 = 2; num_fing = 10; zc = 1p; w = 1u; bias = 63.5u
  Temperature: 27
  Analysis tran: stop=5u
  Output freq(VT("/vout") "rising" ?xName "time" ?mode "auto" ?threshold 0.6)
  Output clip(freq(VT("/vout") "rising" ?xName "time" ?mode "auto" ?threshold 0.6) 4e-09 3e-07) (unticked)
  Signals: /vout, /pll2loop, /iout2, /data_a, /data_b, /data_c, /data_d, /v_one, /v_zero
Run mode: Single Run, Sweeps and Corners
Setup values for test ECE4530SerDes_PLLmodeltb_1: tap1 = 13 15 17 19; tap2 = 2 4 6; tap3 = 2 4 6
