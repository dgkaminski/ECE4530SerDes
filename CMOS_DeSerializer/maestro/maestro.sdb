ADE simulation setup
Run mode: Single Run, Sweeps and Corners
Tests:
  ECE4530SerDes_CMOS_DeSerializer_1: ECE4530SerDes/CMOS_DeSerializer/schematic, simulator spectre
    Variables: w = 800n
