ADE simulation setup
Test ECE4530SerDes_CMOS_DeSerializer_1: ECE4530SerDes/CMOS_DeSerializer/schematic, simulator spectre
  Models: /opt/cadence-designkits/gpdk045_v_6_0/gpdk045/../models/spectre/gpdk045.scs[mc]
  Temperature: 27
  Analysis tran: stop=15n
Run mode: Single Run, Sweeps and Corners
Setup values for test ECE4530SerDes_CMOS_DeSerializer_1: w = 800n
