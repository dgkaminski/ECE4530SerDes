ADE simulation setup
Test ECE4530SerDes_CMOS_DeSerializer_1: ECE4530SerDes/CMOS_DeSerializer/schematic, simulator spectre
  Models: /opt/cadence-designkits/gpdk045_v_6_0/gpdk045/../models/spectre/gpdk045.scs[mc]
  Variables: w = 800n
  Temperature: 27
  Analysis tran: stop=5n
