ADE simulation setup
Test ECE4530SerDes_JustDFE-TB_1: ECE4530SerDes/JustDFE-TB/schematic, simulator spectre
  Models: /opt/cadence-designkits/gpdk045_v_6_0/gpdk045/../models/spectre/gpdk045.scs[mc]
  Variables: tap2 = 0; tap3 = 0; idfe = 1m; tap1 = 15
  Temperature: 27
  Analysis dc: (saves the operating point)
  Signals: /BfrCh, /net3, /dfep, /dfen, /I4/dfen, /I4/dfep
Run mode: Single Run, Sweeps and Corners
Setup values for test ECE4530SerDes_JustDFE-TB_1: tap1 = 25
