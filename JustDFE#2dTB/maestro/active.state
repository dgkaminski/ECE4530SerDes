ADE simulation setup
Test ECE4530SerDes_JustDFE-TB_1: ECE4530SerDes/JustDFE-TB/schematic, simulator spectre
  Models: /opt/cadence-designkits/gpdk045_v_6_0/gpdk045/../models/spectre/gpdk045.scs[mc]
  Variables: idfe = 1m; tap1 = 25
  Temperature: 27
  Analysis tran: stop=100n
  Signals: /BfrCh, /net3, /dfep, /dfen, /I4/dfen, /I4/dfep
Run mode: Single Run, Sweeps and Corners
