ADE simulation setup
Run mode: Single Run, Sweeps and Corners
Tests:
  ECE4530SerDes_JustDFE-TB_1: ECE4530SerDes/JustDFE-TB/schematic, simulator spectre
    Variables: idfe = 1m; tap1 = 25
