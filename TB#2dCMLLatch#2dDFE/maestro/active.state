ADE simulation setup
Test ECE4530SerDes_TB-CMLLatch-DFE_1: ECE4530SerDes/TB-CMLLatch-DFE/schematic, simulator spectre
  Models: /opt/cadence-designkits/gpdk045_v_6_0/gpdk045/../models/spectre/gpdk045.scs[mc]
  Temperature: 27
  Analysis tran: stop=10n errpreset=conservative
  Analysis dc: (saves the operating point)
Run mode: Single Run, Sweeps and Corners
