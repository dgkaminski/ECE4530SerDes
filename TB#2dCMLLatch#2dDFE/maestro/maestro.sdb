ADE simulation setup
Run mode: Single Run, Sweeps and Corners
Tests:
  ECE4530SerDes_TB-CMLLatch-DFE_1: ECE4530SerDes/TB-CMLLatch-DFE/schematic, simulator spectre
