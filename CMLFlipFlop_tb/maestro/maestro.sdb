ADE simulation setup
Run mode: Single Run, Sweeps and Corners
Tests:
  ECE4530SerDes_CMLlatch_1: ECE4530SerDes/CMLFlipFlop_tb/schematic, simulator spectre
    Variables: rload = 7500; ibias = 50u; w = 800n
