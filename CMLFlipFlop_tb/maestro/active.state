ADE simulation setup
Test ECE4530SerDes_CMLlatch_1: ECE4530SerDes/CMLFlipFlop_tb/schematic, simulator spectre
  Models: /opt/cadence-designkits/gpdk045_v_6_0/gpdk045/../models/spectre/gpdk045.scs[mc], /opt/cadence/IC231.007/tools.lnx86/dfII/etc/cdslib/artist/functional/allFunc.scs
  Variables: w = 800n; ibias = 50u; rload = 7500
  Temperature: 27
  Analysis tran: stop=10n outputstart=10p
  Signals: /vinn, /vinp, /clk, /clkn, /outn, /outp
Run mode: Single Run, Sweeps and Corners
