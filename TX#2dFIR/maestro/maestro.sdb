ADE simulation setup
Run mode: Single Run, Sweeps and Corners
Tests:
  ECE4530SerDes_TX-FIR_1: ECE4530SerDes/TX-FIR/schematic, simulator spectre
    Variables: idmain = 100u; tap1 = 50; tap2 = 0; tap3 = 0
