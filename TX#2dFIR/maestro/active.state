ADE simulation setup
Test ECE4530SerDes_TX-FIR_1: ECE4530SerDes/TX-FIR/schematic, simulator spectre
  Models: /opt/cadence-designkits/gpdk045_v_6_0/gpdk045/../models/spectre/gpdk045.scs[mc]
  Variables: idmain = 100u; tap1 = 50; tap2 = 0; tap3 = 0
  Temperature: 27
  Analysis dc: (saves the operating point)
  Analysis tran: stop=5n
  Analysis ac: start=1M stop=10G
Run mode: Single Run, Sweeps and Corners
