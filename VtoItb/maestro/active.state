ADE simulation setup
Test ECE4530SerDes_PLLmodeltb_1: ECE4530SerDes/VtoItb/schematic, simulator spectre
  Models: /opt/cadence-designkits/gpdk045_v_6_0/gpdk045/../models/spectre/gpdk045.scs[mc]
  Temperature: 27
  Analysis ac: start=100 stop=10G
  Analysis noise: start=100 stop=5G oprobe=/IPRB0 iprobe=/V3
  Analysis dc: sweep /V3.dc start=0 stop=1.2 (saves the operating point)
  Analysis tran: stop=10n errpreset=conservative noisefmax=10G
  Signals: /IPRB0/MINUS (terminal)
Run mode: Single Run, Sweeps and Corners
