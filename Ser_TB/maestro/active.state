ADE simulation setup
Test ECE4530SerDes_Ser_TB_1: ECE4530SerDes/Ser_TB/schematic, simulator spectre
  Models: /opt/cadence-designkits/gpdk045_v_6_0/gpdk045/../models/spectre/gpdk045.scs[mc]
  Temperature: 27
  Analysis tran: stop=50n
Run mode: Single Run, Sweeps and Corners
