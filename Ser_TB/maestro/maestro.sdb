ADE simulation setup
Run mode: Single Run, Sweeps and Corners
Tests:
  ECE4530SerDes_Ser_TB_1: ECE4530SerDes/Ser_TB/schematic, simulator spectre
