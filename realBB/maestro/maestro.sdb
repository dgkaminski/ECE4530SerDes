ADE simulation setup
Run mode: Single Run, Sweeps and Corners
Tests:
  ECE4530SerDes_idealBBtb_1: ECE4530SerDes/realBB/schematic, simulator spectre
    Variables: dly = 90p 110p; w = 1u
