ADE simulation setup
Test ECE4530SerDes_idealBBtb_1: ECE4530SerDes/realBB/schematic, simulator spectre
  Models: /opt/cadence-designkits/gpdk045_v_6_0/gpdk045/../models/spectre/gpdk045.scs[mc]
  Variables: w = 1u; dly = 90p
  Temperature: 27
  Analysis tran: stop=10n
  Signals: /early, /late
Run mode: Single Run, Sweeps and Corners
Setup values for test ECE4530SerDes_idealBBtb_1: dly = 90p 110p
