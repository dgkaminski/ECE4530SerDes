ADE simulation setup
Test ECE4530SerDes_PLLmodeltb_1: ECE4530SerDes/PLLrealltb/schematic, simulator spectre
  Models: /opt/cadence-designkits/gpdk045_v_6_0/gpdk045/../models/spectre/gpdk045.scs[mc], /opt/cadence/IC231.007/tools.lnx86/dfII/etc/cdslib/artist/functional/allFunc.scs
  Variables: idfe = 1m; tap1 = 15; tap2 = 0; tap3 = 2; num_fing = 10; zc = 1p; w = 1u; bias = 63.5u
  Temperature: 27
  Analysis tran: stop=10u
  Output freq(VT("/vout") "rising" ?xName "time" ?mode "auto" ?threshold 0.6)
  Output clip(freq(VT("/vout") "rising" ?xName "time" ?mode "auto" ?threshold 0.6) 4e-09 3e-07) (unticked)
  Signals: /vout, /I0/iout (terminal), /I1/biasc (terminal), /I25/biasf (terminal), /I25/biasc (terminal), /I25/vout (terminal), /I25/vdd (terminal), /I25/gnd (terminal), /pll2loop, /iout2
Run mode: Single Run, Sweeps and Corners
